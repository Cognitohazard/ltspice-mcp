* a diode load swept over two saturation currents, a model parameter stepped
V1 in 0 0
R1 in out 1k
D1 out 0 DM
.model DM D(Is=1e-14)
.step D DM(Is) list 1e-14 1e-13
.dc V1 0 4 1
.end
