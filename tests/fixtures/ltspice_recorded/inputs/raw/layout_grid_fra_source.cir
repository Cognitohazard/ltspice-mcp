* frequency response analysis of one loop over two reference voltages, stepped by the source's own name
V1 ref 0 1
E1 a 0 ref c 100
@1 a b fstart=4k fend=32k oct=1 tsettle=50u
R1 b c 1k
C1 c 0 1u
.step V1 list 1 2
.fra
.end
