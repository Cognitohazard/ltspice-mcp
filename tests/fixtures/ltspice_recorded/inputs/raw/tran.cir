* rc step response
V1 in 0 PULSE(0 1 0 1u 1u 1 2)
R1 in out 1k
C1 out 0 100n
.tran 0 1m 0 20u
.meas tran vfinal FIND V(out) AT 0.9m
.meas tran vmax MAX V(out)
.end
