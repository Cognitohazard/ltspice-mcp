* a 1 mV RC charge, saved with the default waveform compression
V1 in 0 PWL(0 0 1u 1m)
R1 in out 1k
C1 out 0 1u
.tran 5m
.meas tran vavg AVG V(out)
.meas tran vat FIND V(out) AT 1m
.end
