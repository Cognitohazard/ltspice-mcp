* m on a subcircuit X line, and a body that multiplies its device by a parameter the X line sets
Vdd vdd 0 1.8
Vg g 0 1.5
V1 vdd d1 0
X1 d1 g 0 cell
VX vdd dx 0
X2 dx g 0 cell m=4
VP vdd dp 0
X3 dp g 0 pcell mult=4
.subckt cell d g s
M0 d g s s NM W=10u L=1u
.ends cell
.subckt pcell d g s params: mult=1
M0 d g s s NM W=10u L=1u m={mult}
.ends pcell
.model NM NMOS(VTO=0.7 KP=100u)
.op
.end
