* a diode-clamped rc charge over two saturation currents, a model parameter stepped
V1 in 0 PULSE(0 1 0 1u 1u 1 2)
R1 in out 1k
C1 out 0 100n
D1 out 0 DM
.model DM D(Is=1e-14)
.step D DM(Is) list 1e-14 1e-13
.tran 0 200u 0 20u
.end
