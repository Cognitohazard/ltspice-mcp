* .save of a current and a node inside nested subcircuit instances, spelled with the instances' X
V1 vdd 0 3
Xa vdd outa stage
.subckt stage top out
Rd top out 10k
Xin top out inner
.ends
.subckt inner p n
Rin p mid 100k
Rlo mid n 50k
.ends
.save I(xa:xin:rin) V(xa:xin:mid) I(xa:rd)
.tran 1u
.end
