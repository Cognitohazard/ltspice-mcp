* frequency response analysis of one loop over two pole resistances
V1 ref 0 1
E1 a 0 ref c 100
@1 a b fstart=4k fend=32k oct=1 tsettle=50u
R1 b c {r}
C1 c 0 1u
.step param r list 1k 2k
.fra
.end
