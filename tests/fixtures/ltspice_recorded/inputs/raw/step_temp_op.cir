* operating point of a resistor with a temperature coefficient over three temperatures
I1 0 a 1m
R1 a 0 1k tc1=0.01
.step temp list -40 27 125
.op
.end
