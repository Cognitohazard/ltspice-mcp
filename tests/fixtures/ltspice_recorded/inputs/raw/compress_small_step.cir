* an RC charge with a sharp corner at 2 ms, saved with the default waveform compression
V1 in 0 PWL(0 0 2m 0 2.000001m 1m)
R1 in out 1k
C1 out 0 1u
.tran 5m
.end
