* RC low-pass at one frequency over three resistances
V1 in 0 AC 1
R1 in out {r}
C1 out 0 1n
.step param r list 1k 2k 4k
.ac list 100k
.end
