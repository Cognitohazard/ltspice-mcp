* the same RC charge at 1 V, saved with the default waveform compression
V1 in 0 PWL(0 0 1u 1)
R1 in out 1k
C1 out 0 1u
.tran 5m
.meas tran vavg AVG V(out)
.meas tran vat FIND V(out) AT 1m
.end
