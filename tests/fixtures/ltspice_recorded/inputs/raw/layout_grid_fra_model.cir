* frequency response analysis of one loop with a diode over two saturation currents, a model parameter stepped
V1 ref 0 1
E1 a 0 ref c 100
@1 a b fstart=4k fend=32k oct=1 tsettle=50u
R1 b c 1k
C1 c 0 1u
D1 c 0 DM
.model DM D(Is=1e-14)
.step D DM(Is) list 1e-14 1e-13
.fra
.end
