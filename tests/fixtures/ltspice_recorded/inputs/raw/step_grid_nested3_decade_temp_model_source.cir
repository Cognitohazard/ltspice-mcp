* three nested .step cards, read for which step each value belongs to
Vin in 0 1
R1 in out {rv}
C1 out 0 {c}
D1 out 0 DM
.model DM D(Is=1e-14)
.param rv=1k c=100n
.step dec temp 1 10 1
.step dec D DM(Is) 1e-15 1e-14 1
.step dec VIN 0.1 1 1
.tran 0 100u 0 5u
.end
