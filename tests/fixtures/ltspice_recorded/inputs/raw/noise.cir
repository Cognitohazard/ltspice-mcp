* rc noise
V1 in 0 AC 1
R1 in out 1k
C1 out 0 100n
.noise V(out) V1 dec 5 10 100k
.end
