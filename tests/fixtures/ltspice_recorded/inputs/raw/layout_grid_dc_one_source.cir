* divider swept over one point with a second source stepped by its own name
V1 in 0 0
R1 in out 1k
R2 out bias 1k
V2 bias 0 0
.step V2 list 1 2 3
.dc V1 3 3 1
.end
