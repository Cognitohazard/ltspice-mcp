* rc low-pass over three resistances
V1 in 0 AC 1
R1 in out {r}
C1 out 0 159.154943n
.step param r list 1k 2k 4k
.ac dec 5 10 100k
.meas ac fc WHEN mag(V(out))=0.70710678
.end
