* .save of a current and a node inside nested subcircuit instances, spelled without the instances' X
V1 vdd 0 3
Xa vdd outa stage
.subckt stage top out
Rd top out 10k
Xin top out inner
.ends
.subckt inner p n
Rin p mid 100k
Rlo mid n 50k
.ends
.save I(a:in:Rin) V(a:in:mid) I(a:Rd)
.tran 1u
.end
