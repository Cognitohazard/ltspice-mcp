* three nested .step cards, read for which step each value belongs to
Vin in 0 1
R1 in out {rv}
C1 out 0 {c}
D1 out 0 DM
.model DM D(Is=1e-14)
.param rv=1k c=100n
.step oct param rv 1k 2k 1
.step oct temp 25 50 1
.step oct D DM(Is) 1e-14 2e-14 1
.tran 0 100u 0 5u
.end
