* rc step response over resistances that need more than six digits
V1 in 0 PULSE(0 1 0 1u 1u 1 2)
R1 in out {r}
C1 out 0 100n
.step param r list 1k 2.1544346900318838k 4.6415888336127789k 100.001 100.002
.tran 0 1m 0 20u
.end
