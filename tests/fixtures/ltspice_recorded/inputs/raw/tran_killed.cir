* a long run stopped part way
V1 n0 0 SINE(0 1 1k)
R1 n0 n1 1k
C1 n1 0 1n
D1 n1 0 DCL
R2 n1 n2 1k
C2 n2 0 1n
D2 n2 0 DCL
R3 n2 n3 1k
C3 n3 0 1n
D3 n3 0 DCL
R4 n3 n4 1k
C4 n4 0 1n
D4 n4 0 DCL
R5 n4 n5 1k
C5 n5 0 1n
D5 n5 0 DCL
R6 n5 n6 1k
C6 n6 0 1n
D6 n6 0 DCL
R7 n6 n7 1k
C7 n7 0 1n
D7 n7 0 DCL
R8 n7 n8 1k
C8 n8 0 1n
D8 n8 0 DCL
R9 n8 n9 1k
C9 n9 0 1n
D9 n9 0 DCL
R10 n9 n10 1k
C10 n10 0 1n
D10 n10 0 DCL
R11 n10 n11 1k
C11 n11 0 1n
D11 n11 0 DCL
R12 n11 n12 1k
C12 n12 0 1n
D12 n12 0 DCL
R13 n12 n13 1k
C13 n13 0 1n
D13 n13 0 DCL
R14 n13 n14 1k
C14 n14 0 1n
D14 n14 0 DCL
R15 n14 n15 1k
C15 n15 0 1n
D15 n15 0 DCL
R16 n15 n16 1k
C16 n16 0 1n
D16 n16 0 DCL
R17 n16 n17 1k
C17 n17 0 1n
D17 n17 0 DCL
R18 n17 n18 1k
C18 n18 0 1n
D18 n18 0 DCL
R19 n18 n19 1k
C19 n19 0 1n
D19 n19 0 DCL
R20 n19 n20 1k
C20 n20 0 1n
D20 n20 0 DCL
R21 n20 n21 1k
C21 n21 0 1n
D21 n21 0 DCL
R22 n21 n22 1k
C22 n22 0 1n
D22 n22 0 DCL
R23 n22 n23 1k
C23 n23 0 1n
D23 n23 0 DCL
R24 n23 n24 1k
C24 n24 0 1n
D24 n24 0 DCL
R25 n24 n25 1k
C25 n25 0 1n
D25 n25 0 DCL
R26 n25 n26 1k
C26 n26 0 1n
D26 n26 0 DCL
R27 n26 n27 1k
C27 n27 0 1n
D27 n27 0 DCL
R28 n27 n28 1k
C28 n28 0 1n
D28 n28 0 DCL
R29 n28 n29 1k
C29 n29 0 1n
D29 n29 0 DCL
R30 n29 n30 1k
C30 n30 0 1n
D30 n30 0 DCL
R31 n30 n31 1k
C31 n31 0 1n
D31 n31 0 DCL
R32 n31 n32 1k
C32 n32 0 1n
D32 n32 0 DCL
R33 n32 n33 1k
C33 n33 0 1n
D33 n33 0 DCL
R34 n33 n34 1k
C34 n34 0 1n
D34 n34 0 DCL
R35 n34 n35 1k
C35 n35 0 1n
D35 n35 0 DCL
R36 n35 n36 1k
C36 n36 0 1n
D36 n36 0 DCL
R37 n36 n37 1k
C37 n37 0 1n
D37 n37 0 DCL
R38 n37 n38 1k
C38 n38 0 1n
D38 n38 0 DCL
R39 n38 n39 1k
C39 n39 0 1n
D39 n39 0 DCL
R40 n39 n40 1k
C40 n40 0 1n
D40 n40 0 DCL
.model DCL D
.save V(n40)
.tran 0 100 0 1u
.end
