* rc step response over three resistances
V1 in 0 PULSE(0 1 0 1u 1u 1 2)
R1 in out {r}
C1 out 0 100n
.step param r list 1k 2k 4k
.tran 0 1m 0 20u
.meas tran vfinal FIND V(out) AT 0.9m
.end
