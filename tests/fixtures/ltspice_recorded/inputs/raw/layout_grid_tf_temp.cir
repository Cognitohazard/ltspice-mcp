* divider transfer function over three temperatures
V1 in 0 5
R1 in out 1k tc1=0.01
R2 out 0 4k
.step temp list -40 27 125
.tf V(out) V1
.end
