* rc low-pass frequency response
V1 in 0 AC 1
R1 in out 1k
C1 out 0 159.154943n
.ac dec 5 10 100k
.meas ac fc WHEN mag(V(out))=0.70710678
.meas ac gain1k FIND V(out) AT 1k
.end
