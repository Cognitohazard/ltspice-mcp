* rc noise at one frequency over three resistances
V1 in 0 AC 1
R1 in out {r}
C1 out 0 100n
.step param r list 1k 2k 4k
.noise V(out) V1 lin 1 1k 1k
.end
