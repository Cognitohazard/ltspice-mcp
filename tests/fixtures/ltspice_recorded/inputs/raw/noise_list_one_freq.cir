* rc noise at one frequency named by a list
V1 in 0 AC 1
R1 in out 1k
C1 out 0 100n
.noise V(out) V1 list 1k
.end
