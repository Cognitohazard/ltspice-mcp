* resistive divider swept, under numdgt above 6
V1 in 0 0
R1 in out 1k
R2 out 0 1k
.options numdgt=7
.dc V1 0 5 1
.end
