* resistive divider swept over one point
V1 in 0 0
R1 in out 1k
R2 out 0 1k
.dc V1 3 3 1
.end
