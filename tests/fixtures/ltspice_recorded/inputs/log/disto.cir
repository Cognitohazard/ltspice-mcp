* a distortion analysis
V1 in 0 AC 1 distof1 1
R1 in out 1k
D1 out 0 DN
.model DN D
.disto dec 5 10 100k
.end
