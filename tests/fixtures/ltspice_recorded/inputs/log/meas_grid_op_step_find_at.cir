* FIND AT in an operating point, stepped: a deck of its own, since a build may refuse the form there
V1 in 0 1
R1 in out 1k
R2 out 0 4k
.step param s list 1 2
.op
.meas op find_at_v FIND V(out) AT 1
.meas op find_at_f FIND V(out) AT 5
.meas op find_at_sf FIND V(out) AT {1+4*(s-1)}
.meas op find_at_sz FIND V(out)*(2-s) AT 1
.end
