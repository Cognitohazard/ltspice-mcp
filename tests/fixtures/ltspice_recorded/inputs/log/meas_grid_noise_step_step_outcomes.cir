* every form failing in the second step (k=100), and every form whose result is 0 in one step (z=0 in the second, or a level of 0 in the first): a noise analysis, stepped
V1 in 0 0 AC 1
R1 in out {r}
C1 out 0 159.154943n
.param r=1k z=(100-k)/99
.step param k list 1 100
.noise V(out) V1 dec 10 10 100k
.meas noise max_sf MAX V(onoise) FROM {2k*k} TO {8k*k}
.meas noise min_sf MIN V(onoise) FROM {2k*k} TO {8k*k}
.meas noise pp_sf PP V(onoise) FROM {2k*k} TO {8k*k}
.meas noise avg_sf AVG V(onoise) FROM {2k*k} TO {8k*k}
.meas noise rms_sf RMS V(onoise) FROM {2k*k} TO {8k*k}
.meas noise integ_sf INTEG V(onoise) FROM {2k*k} TO {8k*k}
.meas noise find_at_sf FIND V(onoise) AT {5k*k}
.meas noise find_when_sf FIND V(inoise) WHEN V(onoise)={2n*k}
.meas noise when_sf WHEN V(onoise)={2n*k}
.meas noise deriv_at_sf DERIV V(onoise) AT {5k*k}
.meas noise deriv_when_sf DERIV V(onoise) WHEN V(onoise)={2n*k}
.meas noise trig_targ_sf TRIG V(onoise) VAL=3n FALL=1 TARG V(onoise) VAL={1n*k} FALL=1
.meas noise param_sf PARAM when_sf*2
.meas noise max_sz MAX V(onoise)*z FROM 2k TO 8k
.meas noise min_sz MIN V(onoise)*z FROM 2k TO 8k
.meas noise pp_sz PP V(onoise)*z FROM 2k TO 8k
.meas noise avg_sz AVG V(onoise)*z FROM 2k TO 8k
.meas noise rms_sz RMS V(onoise)*z FROM 2k TO 8k
.meas noise integ_sz INTEG V(onoise)*z FROM 2k TO 8k
.meas noise find_at_sz FIND V(onoise)*z AT 5k
.meas noise find_when_sz FIND V(inoise)*z WHEN V(onoise)=2n
.meas noise deriv_at_sz DERIV V(onoise)*z AT 5k
.meas noise deriv_when_sz DERIV V(onoise)*z WHEN V(onoise)=2n
.meas noise trig_targ_sz TRIG V(onoise) VAL=3n FALL=1 TARG V(onoise) VAL={3n+(1n-3n)*z} FALL=1
.meas noise param_sz PARAM 2*z
.end
