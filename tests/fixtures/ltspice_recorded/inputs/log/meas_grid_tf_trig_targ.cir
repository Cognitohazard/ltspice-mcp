* TRIG TARG in a transfer function: a deck of its own, since a build may refuse the form there
V1 in 0 1
R1 in out 1k
R2 out 0 4k
.tf V(out) V1
.meas tf trig_targ_v TRIG V(out) VAL=0.8 TARG V(out) VAL=0.8
.meas tf trig_targ_f TRIG V(out) VAL=0.8 TARG V(out) VAL=99
.end
