* a FIND with no point in an AC analysis
.param r=1k
V1 in 0 AC 1
R1 in out {r}
C1 out 0 159.154943n
.ac dec 10 10 100k
.meas ac find_v FIND mag(V(out))
.end
