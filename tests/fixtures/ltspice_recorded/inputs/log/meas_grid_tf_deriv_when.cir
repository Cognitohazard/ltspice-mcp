* DERIV WHEN in a transfer function: a deck of its own, since a build may refuse the form there
V1 in 0 1
R1 in out 1k
R2 out 0 4k
.tf V(out) V1
.meas tf deriv_when_v DERIV V(out) WHEN V(out)=0.8
.meas tf deriv_when_f DERIV V(out) WHEN V(out)=99
.end
