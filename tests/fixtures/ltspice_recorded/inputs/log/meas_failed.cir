* a measurement that cannot be taken, between two that can
V1 in 0 PULSE(0 1 0 1u 1u 1 2)
R1 in out 1k
C1 out 0 100n
.tran 0 1m 0 20u
.meas tran before MAX V(out)
.meas tran never WHEN V(out)=2
.meas tran depends PARAM never*2
.meas tran after MIN V(out)
.end
