* a measurement named with a dash, in the table of a stepped run
V1 in 0 PULSE(0 1 0 1u 1u 1 2)
R1 in out {r}
C1 out 0 100n
.step param r list 1k 2k
.tran 0 1m 0 1u
.meas tran t-max MAX V(out)
.end
