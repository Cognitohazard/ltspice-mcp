* a FIND with no point of a signal the run does not save, in an AC analysis, stepped
V1 in 0 AC 1
R1 in out 1k
C1 out 0 159.154943n
R9 in unsaved 1k
R10 unsaved 0 1k
.save V(in) V(out)
.step param s list 1 2
.ac dec 10 10 100k
.meas ac find_f FIND V(unsaved)
.meas ac param_f PARAM find_f*2
.end
