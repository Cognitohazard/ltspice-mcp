* a sensitivity analysis
V1 in 0 5
R1 in out 1k
R2 out 0 4k
.sens V(out)
.end
