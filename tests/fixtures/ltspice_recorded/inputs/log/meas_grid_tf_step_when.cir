* WHEN in a transfer function, stepped: a deck of its own, since a build may refuse the form there
V1 in 0 1
R1 in out 1k
R2 out 0 4k
.step param s list 1 2
.tf V(out) V1
.meas tf when_v WHEN V(out)=0.8
.meas tf when_f WHEN V(out)=99
.meas tf when_sf WHEN V(out)={0.8*s}
.meas tf param_f PARAM when_f*2
.meas tf param_sf PARAM when_sf*2
.end
