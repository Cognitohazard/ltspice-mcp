* a FIND with no point, and a PARAM of it, in an operating point, stepped
V1 in 0 1
R1 in out 1k
R2 out 0 4k
.step param s list 1 2
.op
.meas op find_v FIND V(out)
.meas op param_v PARAM find_v*2
.meas op find_sz FIND V(out)*(2-s)
.meas op param_sz PARAM find_sz*2
.end
