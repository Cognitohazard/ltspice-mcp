* INTEG in a transfer function, stepped: a deck of its own, since a build may refuse the form there
V1 in 0 1
R1 in out 1k
R2 out 0 {4k*s}
.step param s list 1 2
.tf V(out) V1
.meas tf integ_v INTEG transfer_function FROM 0 TO 1
.meas tf integ_f INTEG transfer_function FROM 2 TO 3
.end
