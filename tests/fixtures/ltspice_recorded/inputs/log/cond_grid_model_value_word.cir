* a model card whose parameter is given a word for a value
V1 in 0 1
R1 in out 1k
D1 out 0 DX
.model DX D(Is=abc)
.op
.end
