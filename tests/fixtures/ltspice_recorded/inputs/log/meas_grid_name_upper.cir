* measurements named in upper case: a line, a TRIG/TARG printed with no colon, and one that fails
.param r=1k
V1 in 0 PULSE(0 1 0 1u 1u 1 2)
R1 in out {r}
C1 out 0 100n
.tran 0 1m 0 1u
.meas tran T_UP WHEN V(out)=0.5
.meas tran T_BARE TRIG V(out) VAL=0.1 RISE=1 TARG V(out) VAL=0.9 RISE=1
.meas tran T_NEVER WHEN V(out)=2
.end
