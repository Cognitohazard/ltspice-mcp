* MAX in an operating point, stepped: a deck of its own, since a build may refuse the form there
V1 in 0 1
R1 in out 1k
R2 out 0 {4k*s}
.step param s list 1 2
.op
.meas op max_v MAX V(out) FROM 0 TO 1
.meas op max_f MAX V(out) FROM 2 TO 3
.end
