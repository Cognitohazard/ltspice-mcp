* every form failing whole: an AC analysis, stepped
V1 in 0 AC 1
R1 in out {r}
C1 out 0 159.154943n
.step param r list 1k 2k
.ac dec 10 10 100k
.meas ac max_f MAX mag(V(out)) FROM 200k TO 800k
.meas ac min_f MIN mag(V(out)) FROM 200k TO 800k
.meas ac pp_f PP mag(V(out)) FROM 200k TO 800k
.meas ac avg_f AVG mag(V(out)) FROM 200k TO 800k
.meas ac rms_f RMS mag(V(out)) FROM 200k TO 800k
.meas ac integ_f INTEG mag(V(out)) FROM 200k TO 800k
.meas ac find_at_f FIND mag(V(out)) AT 1Meg
.meas ac find_when_f FIND ph(V(out)) WHEN mag(V(out))=2
.meas ac when_f WHEN mag(V(out))=2
.meas ac deriv_at_f DERIV mag(V(out)) AT 1Meg
.meas ac deriv_when_f DERIV mag(V(out)) WHEN mag(V(out))=2
.meas ac trig_targ_f TRIG mag(V(out)) VAL=0.9 FALL=1 TARG mag(V(out)) VAL=2 FALL=1
.meas ac param_f PARAM when_f*2
.end
