* DERIV WHEN in an operating point, stepped: a deck of its own, since a build may refuse the form there
V1 in 0 1
R1 in out 1k
R2 out 0 4k
.step param s list 1 2
.op
.meas op deriv_when_v DERIV V(out) WHEN V(out)=0.8
.meas op deriv_when_f DERIV V(out) WHEN V(out)=99
.meas op deriv_when_sf DERIV V(out) WHEN V(out)={0.8*s}
.meas op deriv_when_sz DERIV V(out)*(2-s) WHEN V(out)=0.8
.end
