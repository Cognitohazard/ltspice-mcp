* DERIV WHEN in an operating point, stepped: a deck of its own, since a build may refuse the form there
V1 in 0 1
R1 in out 1k
R2 out 0 {4k*s}
.step param s list 1 2
.op
.meas op deriv_when_v DERIV V(out) WHEN V(out)=0.8
.meas op deriv_when_f DERIV V(out) WHEN V(out)=99
.end
