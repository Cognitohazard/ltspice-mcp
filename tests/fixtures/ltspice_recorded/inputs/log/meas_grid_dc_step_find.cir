* a FIND with no point in a DC sweep, stepped
V1 in 0 0
R1 in out {r}
R2 out 0 1k
.param r=1k z=(100-k)/99
.step param k list 1 100
.dc V1 0 5 0.1
.meas dc find_v FIND V(out)
.meas dc find_sz FIND V(out)*z
.end
