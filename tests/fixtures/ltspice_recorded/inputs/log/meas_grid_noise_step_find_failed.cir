* a FIND with no point of a signal the run does not save, in a noise analysis, stepped
V1 in 0 0 AC 1
R1 in out 1k
C1 out 0 159.154943n
R9 in unsaved 1k
R10 unsaved 0 1k
.save V(in) V(out)
.step param s list 1 2
.noise V(out) V1 dec 10 10 100k
.meas noise find_f FIND V(unsaved)
.meas noise param_f PARAM find_f*2
.end
