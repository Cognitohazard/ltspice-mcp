* a FIND with no point in an AC analysis, stepped
V1 in 0 AC 1
R1 in out {r}
C1 out 0 159.154943n
.param r=1k z=(100-k)/99
.step param k list 1 100
.ac dec 10 10 100k
.meas ac find_v FIND mag(V(out))
.meas ac find_sz FIND mag(V(out))*z
.end
