* a FIND with no point of a signal the run does not save, in a transient, stepped
V1 in 0 PULSE(0 1 0 1u 1u 1 2)
R1 in out 1k
C1 out 0 100n
R9 in unsaved 1k
R10 unsaved 0 1k
.save V(in) V(out)
.step param s list 1 2
.tran 0 1m 0 1u
.meas tran find_f FIND V(unsaved)
.meas tran param_f PARAM find_f*2
.end
