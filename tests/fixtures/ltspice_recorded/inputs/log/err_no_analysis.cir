* a deck with no analysis
V1 a 0 1
R1 a 0 1k
.end
