* a model card with a parameter the device does not know, over three steps
V1 in 0 {v}
R1 in out 1k
D1 out 0 DX
.model DX D(Is=1e-14 Bogus=3)
.step param v list 1 2 3
.op
.end
