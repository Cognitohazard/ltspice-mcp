* a .meas named e, a constant of the expression engine
V1 s 0 SIN(0 1 1k)
R1 s 0 1k
.tran 0 1m 0 10u
.meas tran e MAX V(s)
.meas tran after MIN V(s)
.end
