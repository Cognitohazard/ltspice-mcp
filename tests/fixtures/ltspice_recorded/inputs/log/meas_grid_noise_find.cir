* a FIND with no point in a noise analysis
.param r=1k
V1 in 0 0 AC 1
R1 in out {r}
C1 out 0 159.154943n
.noise V(out) V1 dec 10 10 100k
.meas noise find_v FIND V(onoise)
.end
