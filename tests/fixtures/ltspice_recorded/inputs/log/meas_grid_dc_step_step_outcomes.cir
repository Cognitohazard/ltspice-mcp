* every form failing in the second step (k=100), and every form whose result is 0 in one step (z=0 in the second, or a level of 0 in the first): a DC sweep, stepped
V1 in 0 0
R1 in out {r}
R2 out 0 1k
.param r=1k z=(100-k)/99
.step param k list 1 100
.dc V1 0 5 0.1
.meas dc max_sf MAX V(out) FROM {1*k} TO {4*k}
.meas dc min_sf MIN V(out) FROM {1*k} TO {4*k}
.meas dc pp_sf PP V(out) FROM {1*k} TO {4*k}
.meas dc avg_sf AVG V(out) FROM {1*k} TO {4*k}
.meas dc rms_sf RMS V(out) FROM {1*k} TO {4*k}
.meas dc integ_sf INTEG V(out) FROM {1*k} TO {4*k}
.meas dc find_at_sf FIND V(out) AT {3*k}
.meas dc find_when_sf FIND I(R1) WHEN V(out)={1*k}
.meas dc when_sf WHEN V(out)={1*k}
.meas dc deriv_at_sf DERIV V(out) AT {3*k}
.meas dc deriv_when_sf DERIV V(out) WHEN V(out)={1*k}
.meas dc trig_targ_sf TRIG V(out) VAL=0.5 RISE=1 TARG V(out) VAL={2*k} RISE=1
.meas dc param_sf PARAM when_sf*2
.meas dc max_sz MAX V(out)*z FROM 1 TO 4
.meas dc min_sz MIN V(out)*z FROM 1 TO 4
.meas dc pp_sz PP V(out)*z FROM 1 TO 4
.meas dc avg_sz AVG V(out)*z FROM 1 TO 4
.meas dc rms_sz RMS V(out)*z FROM 1 TO 4
.meas dc integ_sz INTEG V(out)*z FROM 1 TO 4
.meas dc find_at_sz FIND V(out)*z AT 3
.meas dc find_when_sz FIND I(R1)*z WHEN V(out)=1
.meas dc when_sz WHEN V(out)={1*(1-z)}
.meas dc deriv_at_sz DERIV V(out)*z AT 3
.meas dc deriv_when_sz DERIV V(out)*z WHEN V(out)=1
.meas dc trig_targ_sz TRIG V(out) VAL=0.5 RISE=1 TARG V(out) VAL={0.5+(2-0.5)*z} RISE=1
.meas dc param_sz PARAM 2*z
.end
