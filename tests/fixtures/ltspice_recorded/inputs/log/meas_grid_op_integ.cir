* INTEG in an operating point: a deck of its own, since a build may refuse the form there
V1 in 0 1
R1 in out 1k
R2 out 0 4k
.op
.meas op integ_v INTEG V(out) FROM 0 TO 1
.meas op integ_f INTEG V(out) FROM 2 TO 3
.end
