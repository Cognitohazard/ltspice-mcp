* a FIND with no point in a DC sweep
.param r=1k
V1 in 0 0
R1 in out {r}
R2 out 0 1k
.dc V1 0 5 0.1
.meas dc find_v FIND V(out)
.end
