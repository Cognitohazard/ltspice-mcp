* every form with a result: an AC analysis
.param r=1k
V1 in 0 AC 1
R1 in out {r}
C1 out 0 159.154943n
.ac dec 10 10 100k
.meas ac max_v MAX mag(V(out)) FROM 2k TO 8k
.meas ac min_v MIN mag(V(out)) FROM 2k TO 8k
.meas ac pp_v PP mag(V(out)) FROM 2k TO 8k
.meas ac avg_v AVG mag(V(out)) FROM 2k TO 8k
.meas ac rms_v RMS mag(V(out)) FROM 2k TO 8k
.meas ac integ_v INTEG mag(V(out)) FROM 2k TO 8k
.meas ac find_when_v FIND ph(V(out)) WHEN mag(V(out))=0.70710678
.meas ac deriv_at_v DERIV mag(V(out)) AT 5k
.meas ac deriv_when_v DERIV mag(V(out)) WHEN mag(V(out))=0.70710678
.meas ac param_v PARAM max_v*2
.end
