* the expression grid: each source's value is what LTspice computed, as the voltage of its node
.param lpos=6 lneg=-6 lzero=0 rpos=4 rneg=-4 rzero=0 bpos=2 bneg=-2 bzero=0 ewhole=3 eneg=-2 ezero=0 efrac=0.5
V1 e01 0 {lpos+rpos}
V2 e02 0 {lpos+rneg}
V3 e03 0 {lpos+rzero}
V4 e04 0 {lneg+rpos}
V5 e05 0 {lneg+rneg}
V6 e06 0 {lneg+rzero}
V7 e07 0 {lzero+rpos}
V8 e08 0 {lzero+rneg}
V9 e09 0 {lzero+rzero}
V10 e10 0 {lpos-rpos}
V11 e11 0 {lpos-rneg}
V12 e12 0 {lpos-rzero}
V13 e13 0 {lneg-rpos}
V14 e14 0 {lneg-rneg}
V15 e15 0 {lneg-rzero}
V16 e16 0 {lzero-rpos}
V17 e17 0 {lzero-rneg}
V18 e18 0 {lzero-rzero}
V19 e19 0 {lpos*rpos}
V20 e20 0 {lpos*rneg}
V21 e21 0 {lpos*rzero}
V22 e22 0 {lneg*rpos}
V23 e23 0 {lneg*rneg}
V24 e24 0 {lneg*rzero}
V25 e25 0 {lzero*rpos}
V26 e26 0 {lzero*rneg}
V27 e27 0 {lzero*rzero}
V28 e28 0 {lpos/rpos}
V29 e29 0 {lpos/rneg}
V30 e30 0 {lneg/rpos}
V31 e31 0 {lneg/rneg}
V32 e32 0 {lzero/rpos}
V33 e33 0 {lzero/rneg}
V34 e34 0 {bpos**ewhole}
V35 e35 0 {bpos**eneg}
V36 e36 0 {bpos**ezero}
V37 e37 0 {bpos**efrac}
V38 e38 0 {bzero**ewhole}
V39 e39 0 {bzero**efrac}
V40 e40 0 {bpos^ewhole}
V41 e41 0 {bpos^eneg}
V42 e42 0 {bpos^ezero}
V43 e43 0 {bpos^efrac}
V44 e44 0 {bzero^ewhole}
V45 e45 0 {bzero^eneg}
V46 e46 0 {bzero^ezero}
V47 e47 0 {bzero^efrac}
V48 e48 0 {bneg^ewhole}
V49 e49 0 {bneg^eneg}
V50 e50 0 {bneg^ezero}
V51 e51 0 {bneg^efrac}
V52 e52 0 {-lpos}
V53 e53 0 {-lneg}
V54 e54 0 {-lzero}
V55 e55 0 {+lpos}
V56 e56 0 {+lneg}
V57 e57 0 {+lzero}
V58 e58 0 {10-4-3}
V59 e59 0 {64/8/2}
V60 e60 0 {2+3*4}
V61 e61 0 {(2+3)*4}
V62 e62 0 {-2^2}
.param psum=lpos+rpos
V63 e63 0 {psum}
.op
.end
