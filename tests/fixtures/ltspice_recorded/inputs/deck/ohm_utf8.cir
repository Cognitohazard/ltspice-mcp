* a resistance written with an ohm sign
I1 0 a 1
R1 a 0 10Ω
.op
.end
