* a deck whose lines end in a carriage return alone
I01 0 n01 1
R01 n01 0 1k
.op
.end
