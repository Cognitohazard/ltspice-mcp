* a .control region holding a card
.op
I01 0 n01 1
R01 n01 0 1k
.control
R02 n01 0 1k
.endc
.end
