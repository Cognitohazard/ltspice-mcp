* a sectioned .lib
.lib corners.lib tt
I1 0 a 1
R1 a 0 {rval}
.op
.end
