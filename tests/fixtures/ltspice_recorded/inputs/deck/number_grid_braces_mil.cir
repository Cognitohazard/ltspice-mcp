* the number grid: each source's value is the number LTspice read, as the voltage of its node
V1 n01 0 {1mil}
V2 n02 0 {1MIL}
V3 n03 0 {1Mil}
.op
.end
