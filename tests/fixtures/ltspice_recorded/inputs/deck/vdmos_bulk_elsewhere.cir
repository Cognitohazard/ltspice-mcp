* a four-node M card with a VDMOS model whose bulk is not its source
.model VD VDMOS (VTO=2 KP=0.5 CGDMAX=1n CGDMIN=100p CGS=1n CJO=1n IS=1e-12)
VDD vdd 0 10
VG g 0 4 AC 1
RG1 g g1 1k
M1 d1 g1 s1 0 VD
RD1 vdd d1 100
RS1 s1 0 10
.ac dec 2 1k 100meg
.end
