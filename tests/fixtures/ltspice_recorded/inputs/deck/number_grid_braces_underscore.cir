* the number grid: each source's value is the number LTspice read, as the voltage of its node
V1 n01 0 {1_000}
.op
.end
