* a .lib with no section, on a file that declares sections: is rout read
.lib sections.lib
I1 0 a 1
R1 a 0 {rout}
.op
.end
