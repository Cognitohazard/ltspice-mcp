* a plus line right after the title
+ R01 n01 0 2k
I01 0 n01 1
R02 n01 0 2k
.op
.end
