* cards after .end
I1 0 a 1
R1 a 0 1k
.op
.end
R2 a 0 1k
