* a PWL source reading a file named by a relative path
V1 a 0 PWL file=data/level.txt
R1 a 0 1k
.tran 10m
.end
