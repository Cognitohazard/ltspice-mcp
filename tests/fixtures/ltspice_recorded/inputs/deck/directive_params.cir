* .params as a .param
.params rv=2k
I1 0 a 1
R1 a 0 {rv}
.op
.end
