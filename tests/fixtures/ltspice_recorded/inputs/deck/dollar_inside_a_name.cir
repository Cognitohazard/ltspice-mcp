* a dollar sign inside a node name, as PSpice names nets
I1 0 N$1 1
R1 N$1 0 1k
.op
.end
