* a power with a negative base, set in a .param: each source's value is what LTspice computed, as the voltage of its node
.param b=3
.param p1=(-2)**2 p2=-2**2
V1 e01 0 {p1}
V2 e02 0 {p2}
.op
.end
