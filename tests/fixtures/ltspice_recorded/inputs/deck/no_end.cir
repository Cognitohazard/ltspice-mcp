* a deck without .end
I1 0 a 1
R1 a 0 1k
.op
