* charge and flux given as expressions
V1 a 0 PULSE(0 1 0 1u 1u 1 2)
R1 a b 1k
C1 b 0 Q=100n*x
R2 a c 1k
L1 c 0 Flux=1m*x
.tran 0 1m 0 20u
.meas tran vb FIND V(b) AT 0.5m
.meas tran vc FIND V(c) AT 1u
.end
