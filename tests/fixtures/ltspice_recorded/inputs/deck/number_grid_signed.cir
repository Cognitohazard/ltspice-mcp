* the number grid: each source's value is the number LTspice read, as the voltage of its node
V1 n01 0 +1
V2 n02 0 +1k
V3 n03 0 +1k5
V4 n04 0 +1r5
V5 n05 0 +1V5
V6 n06 0 -1
V7 n07 0 -1k
V8 n08 0 -1k5
V9 n09 0 -1r5
V10 n10 0 -1V5
.op
.end
