* a three-node M card with a VDMOS model beside the four-node card with the bulk at the source
* The gate is driven through a resistor, so the gate and body diode
* capacitances shape the response.
.model VD VDMOS (VTO=2 KP=0.5 CGDMAX=1n CGDMIN=100p CGS=1n CJO=1n IS=1e-12)
VDD vdd 0 10
VG g 0 4 AC 1
RG1 g g1 1k
M1 d1 g1 s1 VD
RD1 vdd d1 100
RS1 s1 0 10
RG2 g g2 1k
M2 d2 g2 s2 s2 VD
RD2 vdd d2 100
RS2 s2 0 10
.ac dec 2 1k 100meg
.end
