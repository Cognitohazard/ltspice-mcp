* behavioural resistor
I1 0 a 1
B1 a 0 R=1k
.op
.end
