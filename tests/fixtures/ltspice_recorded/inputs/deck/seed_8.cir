* random functions under .options seed=8
.options seed=8
I1 0 a 1
R1 a 0 {mc(1k,0.1)}
I2 0 b 1
R2 b 0 {1k+gauss(100)}
I3 0 c 1
R3 c 0 {1k+flat(100)}
.op
.end
