* scale suffixes and unit tails: each resistor carries 1 A, so V(n<i>) is the resistance LTspice read
I1 0 n01 1
R1 n01 0 1k
I2 0 n02 1
R2 n02 0 1K
I3 0 n03 1
R3 n03 0 1Meg
I4 0 n04 1
R4 n04 0 1MEG
I5 0 n05 1
R5 n05 0 1meg
I6 0 n06 1
R6 n06 0 1M
I7 0 n07 1
R7 n07 0 1m
I8 0 n08 1
R8 n08 0 1u
I9 0 n09 1
R9 n09 0 1U
I10 0 n10 1
R10 n10 0 1n
I11 0 n11 1
R11 n11 0 1p
I12 0 n12 1
R12 n12 0 1f
I13 0 n13 1
R13 n13 0 1T
I14 0 n14 1
R14 n14 0 1t
I15 0 n15 1
R15 n15 0 1G
I16 0 n16 1
R16 n16 0 1g
I17 0 n17 1
R17 n17 0 1mil
I18 0 n18 1
R18 n18 0 1MIL
I19 0 n19 1
R19 n19 0 1e3
I20 0 n20 1
R20 n20 0 1E3
I21 0 n21 1
R21 n21 0 1.5k
I22 0 n22 1
R22 n22 0 1e3k
I23 0 n23 1
R23 n23 0 .5k
I24 0 n24 1
R24 n24 0 1.k
I25 0 n25 1
R25 n25 0 1kOhm
I26 0 n26 1
R26 n26 0 1uF
I27 0 n27 1
R27 n27 0 1mV
I28 0 n28 1
R28 n28 0 1pF
I29 0 n29 1
R29 n29 0 1megohm
I30 0 n30 1
R30 n30 0 1kHz
.op
.end
