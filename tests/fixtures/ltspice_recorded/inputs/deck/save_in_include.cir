* a .save in an included file
.include probes.inc
V1 in 0 PULSE(0 1 0 1u 1u 1 2)
R1 in out 1k
C1 out 0 100n
.tran 0 1m 0 1u
.meas tran vout FIND V(out) AT 0.5m
.end
