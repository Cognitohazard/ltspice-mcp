* the temperature set through .options and .temp
.temp 50
V1 a 0 1
R1 a 0 1k tc1=0.01
.op
.end
