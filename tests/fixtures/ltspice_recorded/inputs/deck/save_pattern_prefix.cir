* .save names the voltages starting with o: which does it save?
V1 in 0 PULSE(0 1 0 1u 1u 1 2)
R1 in mid 1k
R2 mid out 1k
C1 out 0 100n
.save V(o*)
.tran 0 1m 0 20u
.meas tran vout FIND V(out) AT 0.9m
.meas tran vmid FIND V(mid) AT 0.9m
.end
