* a form feed between two cards on one line
I01 0 n01 1
R01 n01 0 1kR02 n01 0 1k
.op
.end
