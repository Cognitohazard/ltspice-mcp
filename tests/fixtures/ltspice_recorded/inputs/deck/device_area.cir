* trailing area factors
V1 vcc 0 5
R1 vcc c 1k
R2 vcc b 100k
Q1 c b 0 0 QN 2
R3 vcc c2 1k
R4 vcc b2 100k
Q2 c2 b2 0 QN 2
R5 vcc d 1k
D1 d 0 DN 3
.model QN NPN
.model DN D
.op
.end
