* is gnd! ground, or a node of its own
I1 0 a 1
R1 a gnd! 1k
R2 gnd! 0 1k
.op
.end
