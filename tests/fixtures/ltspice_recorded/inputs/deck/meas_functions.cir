* functions of a complex quantity inside .meas
V1 in 0 AC 1
R1 in out 1k
C1 out 0 159.154943n
.ac dec 10 10 100k
.meas ac g_mag FIND mag(V(out)) AT 1k
.meas ac g_ph FIND ph(V(out)) AT 1k
.meas ac g_re FIND re(V(out)) AT 1k
.meas ac g_im FIND im(V(out)) AT 1k
.meas ac g_db FIND db(V(out)) AT 1k
.end
