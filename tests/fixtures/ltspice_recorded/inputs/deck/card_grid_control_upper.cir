* a .CONTROL region holding a card
.op
I01 0 n01 1
R01 n01 0 1k
.CONTROL
R02 n01 0 1k
.ENDC
.end
