* divider operating point, run from a file with two dots in its name
V1 in 0 5
R1 in out 1k
R2 out 0 4k
.op
.end
