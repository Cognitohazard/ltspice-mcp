* unknown model parameter
V1 in 0 1
R1 in out 1k
D1 out 0 DX
.model DX D(Is=1e-14 Bogus=3)
.op
.end
