* R-2R ladder of 25 sections: a series spine with a 2R shunt to ground at each node
* names: out
V1 out 0 5
RS0 out a0 1k
RS1 a0 a1 1k
RS2 a1 a2 1k
RS3 a2 a3 1k
RS4 a3 a4 1k
RS5 a4 a5 1k
RS6 a5 a6 1k
RS7 a6 a7 1k
RS8 a7 a8 1k
RS9 a8 a9 1k
RS10 a9 a10 1k
RS11 a10 a11 1k
RS12 a11 a12 1k
RS13 a12 a13 1k
RS14 a13 a14 1k
RS15 a14 a15 1k
RS16 a15 a16 1k
RS17 a16 a17 1k
RS18 a17 a18 1k
RS19 a18 a19 1k
RS20 a19 a20 1k
RS21 a20 a21 1k
RS22 a21 a22 1k
RS23 a22 a23 1k
RS24 a23 a24 1k
RT0 a0 0 2k
RT1 a1 0 2k
RT2 a2 0 2k
RT3 a3 0 2k
RT4 a4 0 2k
RT5 a5 0 2k
RT6 a6 0 2k
RT7 a7 0 2k
RT8 a8 0 2k
RT9 a9 0 2k
RT10 a10 0 2k
RT11 a11 0 2k
RT12 a12 0 2k
RT13 a13 0 2k
RT14 a14 0 2k
RT15 a15 0 2k
RT16 a16 0 2k
RT17 a17 0 2k
RT18 a18 0 2k
RT19 a19 0 2k
RT20 a20 0 2k
RT21 a21 0 2k
RT22 a22 0 2k
RT23 a23 0 2k
RT24 a24 0 2k
.op
.end
