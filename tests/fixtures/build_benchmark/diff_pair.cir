* Differential pair with resistor loads and a tail current source
* names: vdd inp inn outp outn tail
Vdd vdd 0 5
Vinp inp 0 SINE(2.5 10m 1k)
Vinn inn 0 2.5
R1 vdd outn 10k
R2 vdd outp 10k
M1 outn inp tail 0 NMOS_MOD
M2 outp inn tail 0 NMOS_MOD
Itail tail 0 200u
.model NMOS_MOD NMOS(Kp=200u Vto=0.7)
.tran 5m
.end
