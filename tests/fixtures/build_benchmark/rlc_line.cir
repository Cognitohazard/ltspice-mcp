* Lossy RLC line of 50 sections, driven through a source resistance into a matched load
* names: in out
V1 in 0 AC 1
Rs in n0 50
L0 n0 n1 10n
C0 n1 0 4p
R0 n1 0 100k
L1 n1 n2 10n
C1 n2 0 4p
R1 n2 0 100k
L2 n2 n3 10n
C2 n3 0 4p
R2 n3 0 100k
L3 n3 n4 10n
C3 n4 0 4p
R3 n4 0 100k
L4 n4 n5 10n
C4 n5 0 4p
R4 n5 0 100k
L5 n5 n6 10n
C5 n6 0 4p
R5 n6 0 100k
L6 n6 n7 10n
C6 n7 0 4p
R6 n7 0 100k
L7 n7 n8 10n
C7 n8 0 4p
R7 n8 0 100k
L8 n8 n9 10n
C8 n9 0 4p
R8 n9 0 100k
L9 n9 n10 10n
C9 n10 0 4p
R9 n10 0 100k
L10 n10 n11 10n
C10 n11 0 4p
R10 n11 0 100k
L11 n11 n12 10n
C11 n12 0 4p
R11 n12 0 100k
L12 n12 n13 10n
C12 n13 0 4p
R12 n13 0 100k
L13 n13 n14 10n
C13 n14 0 4p
R13 n14 0 100k
L14 n14 n15 10n
C14 n15 0 4p
R14 n15 0 100k
L15 n15 n16 10n
C15 n16 0 4p
R15 n16 0 100k
L16 n16 n17 10n
C16 n17 0 4p
R16 n17 0 100k
L17 n17 n18 10n
C17 n18 0 4p
R17 n18 0 100k
L18 n18 n19 10n
C18 n19 0 4p
R18 n19 0 100k
L19 n19 n20 10n
C19 n20 0 4p
R19 n20 0 100k
L20 n20 n21 10n
C20 n21 0 4p
R20 n21 0 100k
L21 n21 n22 10n
C21 n22 0 4p
R21 n22 0 100k
L22 n22 n23 10n
C22 n23 0 4p
R22 n23 0 100k
L23 n23 n24 10n
C23 n24 0 4p
R23 n24 0 100k
L24 n24 n25 10n
C24 n25 0 4p
R24 n25 0 100k
L25 n25 n26 10n
C25 n26 0 4p
R25 n26 0 100k
L26 n26 n27 10n
C26 n27 0 4p
R26 n27 0 100k
L27 n27 n28 10n
C27 n28 0 4p
R27 n28 0 100k
L28 n28 n29 10n
C28 n29 0 4p
R28 n29 0 100k
L29 n29 n30 10n
C29 n30 0 4p
R29 n30 0 100k
L30 n30 n31 10n
C30 n31 0 4p
R30 n31 0 100k
L31 n31 n32 10n
C31 n32 0 4p
R31 n32 0 100k
L32 n32 n33 10n
C32 n33 0 4p
R32 n33 0 100k
L33 n33 n34 10n
C33 n34 0 4p
R33 n34 0 100k
L34 n34 n35 10n
C34 n35 0 4p
R34 n35 0 100k
L35 n35 n36 10n
C35 n36 0 4p
R35 n36 0 100k
L36 n36 n37 10n
C36 n37 0 4p
R36 n37 0 100k
L37 n37 n38 10n
C37 n38 0 4p
R37 n38 0 100k
L38 n38 n39 10n
C38 n39 0 4p
R38 n39 0 100k
L39 n39 n40 10n
C39 n40 0 4p
R39 n40 0 100k
L40 n40 n41 10n
C40 n41 0 4p
R40 n41 0 100k
L41 n41 n42 10n
C41 n42 0 4p
R41 n42 0 100k
L42 n42 n43 10n
C42 n43 0 4p
R42 n43 0 100k
L43 n43 n44 10n
C43 n44 0 4p
R43 n44 0 100k
L44 n44 n45 10n
C44 n45 0 4p
R44 n45 0 100k
L45 n45 n46 10n
C45 n46 0 4p
R45 n46 0 100k
L46 n46 n47 10n
C46 n47 0 4p
R46 n47 0 100k
L47 n47 n48 10n
C47 n48 0 4p
R47 n48 0 100k
L48 n48 n49 10n
C48 n49 0 4p
R48 n49 0 100k
L49 n49 out 10n
C49 out 0 4p
R49 out 0 100k
RL out 0 50
.ac dec 50 1meg 10g
.end
